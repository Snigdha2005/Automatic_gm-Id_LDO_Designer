* C:\Users\SnigdhaYS\Documents\LTSpice_LDO_Automation\Internally_Compensated\Miller_LDO_Sim_Benches_502\LDO_Transient_IIIT.asc
M1 OTAout Vref N002 N002 nmos292p L=l1 W=Wdiff
M2 N001 OUT N002 N002 nmos292p L=l1 W=Wdiff
M3 N002 Bias 0 0 nmos292p L=0.18u W=10u
M4 N001 N001 Vdd Vdd pmos292p L=l2 W=Wload
M5 OTAout N001 Vdd Vdd pmos292p L=l2 W=Wload
MPass OUT OTAout Vdd Vdd pmos292p L=0.18u W=Wpass
M7 OUT Bias 0 0 nmos292p L=0.18u W=10u
V1 Vdd 0 {Vin} AC 1
V2 Vref 0 {Vout}
M8 Bias Bias 0 0 nmos292p L=0.18u W=10u
I1 Vdd Bias {ibias}
Iload OUT 0 PULSE({iload_min} {Iload} {tdelay} {trise} {tfall} {ton} {tperiod} {ncycles})
C2 OUT 0 {Cload}
C1 OTAout OUT {Cc}
.model NMOS NMOS
.model PMOS PMOS
.lib C:\Users\SnigdhaYS\Documents\LTspiceXVII\lib\cmp\standard.mos
.include C:\Users\SnigdhaYS\Documents\LTSpice_LDO_Automation\models_292p.txt
;.ac dec 20 10 1G
.op
;.step param Wload 50u 200u 50u
.tran 4m
.param ibias=0.5u
.param l1=1.26u
* Please set the parameters in all the .param statements below
.param Wload=0.8022373012367914u
.param Wdiff=0.32712894007182364u
.param Wpass=600.8020892921824u
* Also, set the capacitance values
.param iload_min=0.5m
.param tdelay=0.0m
.param trise=0.001m
.param tfall=0.001m
.param ton=0.25m
.param tperiod=0.5m
.param Iload=1.0m
.param l2=0.72u
.param Vin=0.8
.param Vout=0.6
.param Cload=0.002u
.param ncycles=1000.0m
.param Cc=5.99831199946929e-07u
.backanno
.end
