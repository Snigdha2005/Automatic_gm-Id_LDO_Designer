* C:\Users\SnigdhaYS\Documents\LTSpice_LDO_Automation\Internally_Compensated\Miller_LDO_Sim_Benches_502\LDO_loopgain_IIIT.asc
.temp 27
M1 OTAout Vref N003 N003 nmos292p L=l1 W=Wdiff
M2 N001 N002 N003 N003 nmos292p L=l1 W=Wdiff
M3 N003 Bias 0 0 nmos292p L=1u W=10u
M4 N001 N001 Vdd Vdd pmos292p L=l2 W=Wload
M5 OTAout N001 Vdd Vdd pmos292p L=l2 W=Wload
MPass OUT OTAout Vdd Vdd pmos292p L=0.18u W=Wpass
M7 OUT Bias 0 0 nmos292p L=1u W=10u
V1 Vdd 0 {Vin} AC 0
V2 Vref 0 {Vout}
M8 Bias Bias 0 0 nmos292p L=1u W=10u
I1 Vdd Bias {ibias}
Iload OUT 0 {Iload}
C2 OUT 0 {Cload}
C1 OTAout OUT {Cc}
V3 N002 N004 0 AC 1
R1 OUT N004 1G
C3 N004 0 1
.model NMOS NMOS
.model PMOS PMOS
.lib C:\Users\SnigdhaYS\Documents\LTspiceXVII\lib\cmp\standard.mos
.include C:\Users\SnigdhaYS\Documents\LTSpice_LDO_Automation\models_292p.txt
;.step param Cc 1p 20p 10p
;.step param Iload 2m 10m 8m
.ac dec 20 10 1G
.op
.param ibias=0.5u
.param Iload=1.0m
.param l1=1.26u
.param l2=0.72u
;tran 400u
* Please set the parameters in all the .param statements below
.param Wload=0.8022373012367914u
.param Wdiff=0.32712894007182364u
.param Wpass=600.8020892921824u
.param Cload=0.002u
* Also, set the capacitance values
* You can also use the middlebrook mthod to find the stability.
* Please set the parameters in all the .param statements below
* The method here of breaking the loop and evaluating loop gain works well for a high impedance node, but not always.
* Middlebrook method is the best way to go. You can find an example in the educational folder of examples in LTspice folder.
* AC analysis
.param Vin=0.8
.param Vout=0.6
.param Cc=5.99831199946929e-07u
.backanno
.end
